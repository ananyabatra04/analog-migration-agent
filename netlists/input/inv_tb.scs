// Design: capstone_tmc03/inv_tb
simulator lang=spectre
global 0 vdd!
include "/users/ugrad/ananyb2/CAPSTONE/ncsu-cdk-1.6.0/models/spectre/standalone/tsmc25N.m"
include "/users/ugrad/ananyb2/CAPSTONE/ncsu-cdk-1.6.0/models/spectre/standalone/tsmc25P.m"

// capstone_tmc03/inv/schematic
subckt inv vdd vin vout inh_inh_bn
    M0 (vout vin 0 gnd!) tsmc25N w=450.0n l=300n m=1 region=sat
    M1 (vout vin vdd vdd!) tsmc25P w=450.0n l=300n m=1 region=sat
ends inv

// capstone_tmc03/inv_tb/schematic
I5 (vdd! net1 net2 0) inv
V1 (net1 0) vsource type=pulse val0=0 val1=2.5 period=10n delay=0 rise=100.0p fall=100.0p width=4.9n
C0 (net2 0) capacitor c=100 m=1
include "./_graphical_stimuli.scs"
simulatorOptions options temp=27
tran tran stop=50n
save
